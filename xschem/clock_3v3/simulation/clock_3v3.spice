** sch_path: /home/ttuser/babys-first-adc/xschem/clock_3v3/clock_3v3.sch
.subckt clock_3v3 CLK_3V3 CLK VSS_3V3 VDD_3V3 CLKB CLKB_3V3
*.PININFO CLK:I CLK_3V3:O CLKB_3V3:O VSS_3V3:B VDD_3V3:B CLKB:I
XM1 RCLKB_3V3 CLK VSS_3V3 VSS_3V3 sky130_fd_pr__nfet_g5v0d10v5 L=0.5 W=1 nf=1 m=1
XM2 VSS_3V3 CLKB RCLK_3V3 VSS_3V3 sky130_fd_pr__nfet_g5v0d10v5 L=0.5 W=1 nf=1 m=1
XM3 RCLKB_3V3 RCLK_3V3 VDD_3V3 VDD_3V3 sky130_fd_pr__pfet_g5v0d10v5 L=1.5 W=0.5 nf=1 m=1
XM4 VDD_3V3 RCLKB_3V3 RCLK_3V3 VDD_3V3 sky130_fd_pr__pfet_g5v0d10v5 L=1.5 W=0.5 nf=1 m=1
x7 net2 VSS_3V3 VSS_3V3 VDD_3V3 VDD_3V3 CLKB_3V3 sky130_fd_sc_hvl__inv_2
x8 net1 VSS_3V3 VSS_3V3 VDD_3V3 VDD_3V3 CLK_3V3 sky130_fd_sc_hvl__inv_2
x1 VDD_3V3 RCLKB_3V3 RCLK_3V3 VSS_3V3 net2 net1 nonoverlapping_generator
.ends

* expanding   symbol:  clock_3v3/nonoverlapping_generator.sym # of pins=6
** sym_path: /home/ttuser/babys-first-adc/xschem/clock_3v3/nonoverlapping_generator.sym
** sch_path: /home/ttuser/babys-first-adc/xschem/clock_3v3/nonoverlapping_generator.sch
.subckt nonoverlapping_generator VDD X XB VSS Y YB
*.PININFO VSS:B VDD:B X:I XB:I YB:O Y:O
XM1 YB X VDD VDD sky130_fd_pr__pfet_g5v0d10v5 L=0.5 W=0.5 nf=1 m=1
XM2 net1 X YB VSS sky130_fd_pr__nfet_g5v0d10v5 L=0.5 W=1 nf=1 m=1
XM3 YB Y VDD VDD sky130_fd_pr__pfet_g5v0d10v5 L=0.5 W=0.5 nf=1 m=1
XM4 VSS Y net1 VSS sky130_fd_pr__nfet_g5v0d10v5 L=0.5 W=1 nf=1 m=1
XM5 Y XB VDD VDD sky130_fd_pr__pfet_g5v0d10v5 L=0.5 W=0.5 nf=1 m=1
XM6 net2 XB Y VSS sky130_fd_pr__nfet_g5v0d10v5 L=0.5 W=1 nf=1 m=1
XM7 Y YB VDD VDD sky130_fd_pr__pfet_g5v0d10v5 L=0.5 W=0.5 nf=1 m=1
XM8 VSS YB net2 VSS sky130_fd_pr__nfet_g5v0d10v5 L=0.5 W=1 nf=1 m=1
.ends

.end
